* RC Low-Pass Filter — starter template
* Run: ngspice rc_filter.cir

Vin in 0 AC 1 PULSE(0 5 0 1n 1n 500u 1m)

R1 in out 1k
C1 out 0 100n

.tran 10u 5m
.ac dec 100 10 1Meg

.control
run
set hcopydevtype=svg
hardcopy rc_filter.svg v(in) v(out)
quit
.endc

.end
